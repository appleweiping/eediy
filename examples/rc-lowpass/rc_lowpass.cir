* EEDIY RC low-pass: independent ngspice simulation, never measurement data
* Ideal reference: R=1 kohm, C=1 uF, tau=1 ms, fc=159.154943 Hz
.param RVAL=1k
.param CVAL=1u
.param TDELAY=2m

VSTEP in 0 DC 0 AC 1 PULSE(0 1 {TDELAY} 100n 100n 20m 40m)
R1 in out {RVAL}
C1 out 0 {CVAL}

.control
set noaskquit
set wr_singlescale
set wr_vecnames
option numdgt=15

op
print v(in) v(out)

tran 2u 14m
meas tran t0 WHEN v(in)=0.5 RISE=1
meas tran t63 WHEN v(out)=0.6321205588285577 RISE=1
let tau63 = t63 - t0
print t0 t63 tau63
wrdata build/ngspice_step.dat v(in) v(out)

ac dec 40 1 100k
let h = v(out)/v(in)
meas ac f3db WHEN vdb(out)=-3.010299956639812 FALL=1
print f3db
wrdata build/ngspice_ac.dat real(h) imag(h)

quit
.endc
.end
